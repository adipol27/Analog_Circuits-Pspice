** Profile: "SCHEMATIC1-sim"  [ C:\Users\Or\Dropbox\סמסטר 5\מעגלים אנלוגיים\פרויקט\pspice_circuit\circuit_308552967_308256304-PSpiceFiles\SCHEMATIC1\sim.sim ]

** Creating circuit file "sim.cir"
** WARNING: THIS AUTOMATICALLY GENERATED FILE MAY BE OVERWRITTEN BY SUBSEQUENT SIMULATIONS

*Libraries:
* Profile Libraries :
* Local Libraries :
* From [PSPICE NETLIST] section of C:\Users\Or\AppData\Roaming\SPB_Data\cdssetup\OrCAD_PSpice\17.2.0\PSpice.ini file:
.lib "nomd.lib"

*Analysis directives:
.AC DEC 1000 100Hz 100MegHz
.OPTIONS ADVCONV
.PROBE64 V(alias(*)) I(alias(*)) W(alias(*)) D(alias(*)) NOISE(alias(*))
.INC "..\SCHEMATIC1.net"

.END
